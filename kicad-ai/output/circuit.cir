.SUBCKT CIRCUIT

R1 +12V VOUT 47K
R2 VOUT 0 10K
VP1 +12V 0 DC +12

.ENDS
